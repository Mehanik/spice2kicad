* Two-stage RC-coupled common-emitter amplifier.
* Two cascaded gain stages (Q1 → CC → Q2) sharing one VCC rail. A rooted
* left→right multi-stage flow (in → b1 → c1 → b2 → c2 → out) that the
* current placer sprawls; the flow architecture should compact it.
*@symbol Device:R_US      for=R*
*@symbol Device:C         for=C*
*@symbol Device:Q_NPN_BCE for=Q*
*@port in=input
*@port out=output

VCC vcc 0   DC 12         ;@ power=+12V
VIN in  0   AC 1          ;@ ignore

* --- stage 1 ---
CIN in  b1  1u
RB1 vcc b1  100k
RB2 b1  0   22k
RC1 vcc c1  4k7
RE1 e1  0   1k
CE1 e1  0   100u
Q1  c1 b1 e1 QGENERIC

* --- interstage coupling ---
CC  c1  b2  1u

* --- stage 2 ---
RB3 vcc b2  100k
RB4 b2  0   22k
RC2 vcc c2  4k7
RE2 e2  0   1k
CE2 e2  0   100u
Q2  c2 b2 e2 QGENERIC

COUT c2 out 1u
RL   out 0  100k          ;@ ignore

.model QGENERIC NPN (BF=200 IS=1e-15)
.ac dec 20 10 10Meg
.end
