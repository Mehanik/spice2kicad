* Inverting op-amp: gain = -Rf/Rin = -10.
* Op-amp modelled as a .subckt so it lands on its own hierarchical sheet.
*@symbol Device:R_US for=R*
* `*@port` on the INPUT nets. The emitter already stamps
* `(shape input)` on an undeclared interface net, so the token states
* nothing and ADR-28's metric D2 (`port.label_backwards`) grades only
* terminals the SOURCE declares. Declaring them is the ADR's own
* remedy for its ambiguity 15, and it is free: the emitted file is
* byte-identical with and without these lines (the default the
* declaration replaces is the same direction).
*@port in=input

.subckt OPAMP inp inn out vcc vee
* Trivial VCVS model — fine for a topology round-trip.
E1 out 0 inp inn 1e5
.ends

VCC vcc 0   DC  15   ;@ power=+15V
VEE vee 0   DC -15   ;@ power=-15V
VIN in  0   AC 1     ;@ ignore

RIN in  inv 1k
RF  inv out 10k

X1  0 inv out vcc vee OPAMP

.ac dec 10 1 1Meg
.end
