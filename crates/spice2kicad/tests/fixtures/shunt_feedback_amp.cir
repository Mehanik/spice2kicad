* Shunt-feedback (collector-to-base) common-emitter amplifier.
* RF from collector `c` back to base `b` is a real feedback path: the
* flow graph marks Q1 forward (b→c) and RF backward (c→b), so this is
* the first suite fixture with a visible, un-hidden feedback arc.
*@symbol Device:R_US      for=R*
*@symbol Device:C         for=C*
*@symbol Device:Q_NPN_BCE for=Q*
*@port in=input
*@port out=output

VCC vcc 0   DC 12         ;@ power=+12V
VIN in  0   AC 1          ;@ ignore

CIN in  b   1u
RB  vcc b   100k
RF  c   b   220k
RC  vcc c   4k7
RE  e   0   1k
CE  e   0   100u
COUT c   out 1u
RL  out 0   100k          ;@ ignore

Q1  c b e   QGENERIC

.model QGENERIC NPN (BF=200 IS=1e-15)
.ac dec 20 10 10Meg
.end
