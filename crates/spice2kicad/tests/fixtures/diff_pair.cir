* BJT differential pair with resistive tail and matched collector loads.
*@symbol Device:R_US      for=R*
*@symbol Device:Q_NPN_BCE for=Q*
* `*@port` on the INPUT nets. The emitter already stamps
* `(shape input)` on an undeclared interface net, so the token states
* nothing and ADR-28's metric D2 (`port.label_backwards`) grades only
* terminals the SOURCE declares. Declaring them is the ADR's own
* remedy for its ambiguity 15, and it is free: the emitted file is
* byte-identical with and without these lines (the default the
* declaration replaces is the same direction).
* `in2` is the terminal ambiguity 15 names as the blind spot.
*@port in1=input
*@port in2=input
*@align horizontal Q1 Q2
*@align horizontal RC1 RC2

VCC vcc 0   DC  12   ;@ power=+12V
VEE vee 0   DC -12   ;@ power=-12V
VIN1 in1 0  AC 1     ;@ ignore
VIN2 in2 0  AC 0     ;@ ignore

RC1 vcc c1  4k7
RC2 vcc c2  4k7      ;@ place=right-of RC1
RTAIL tail vee 2k2

Q1  c1 in1 tail QGENERIC
Q2  c2 in2 tail QGENERIC   ;@ place=right-of Q1

.model QGENERIC NPN (BF=200 IS=1e-15)
.ac dec 10 1 10Meg
.end
