* 10:1 compensated attenuator — the front end of an oscilloscope probe.
*
* THE ORIGINAL PREMISE OF THIS FIXTURE WAS WRONG, and the correction is
* recorded here rather than deleted, because the wrong premise is what
* a reader would otherwise re-derive.
*
* It was added as a specimen for metric D's ambiguity 13 (ADR-28, second
* amendment) — "a circuit whose signal path is conventionally drawn
* VERTICALLY", on the claim that a probe divider has the tip at the top,
* the tap in the middle, the shield at the bottom, and that "no textbook
* draws it sideways".
*
* That claim does not survive checking. Six reference schematics were
* fetched and read directly (de.wikipedia "Tastkopf"; electrosome
* "Compensated Attenuator"; Keysight AN 5988-6515EN fig. 1; Harvey Mudd
* E153 Lab 1 fig. 1, citing H&H pp. 1045-1049; Teledyne LeCroy AN016
* fig. 3; an EveryCircuit reproduction of AoE fig. 3N.5). ALL SIX draw
* it HORIZONTALLY — tip left, scope right, ground as a continuous bottom
* rail — with the output tap leaving to the right at the R2/C2 node.
* The one vertical drawing found is a different, richer circuit (a
* three-range switched attenuator). Caveat kept deliberately: The Art of
* Electronics itself could not be accessed, only two indirect witnesses.
*
* So the placer's horizontal axis is CORRECT here, and this fixture does
* NOT exercise ambiguity 13 — as drawn it emits `out` at rot 0.
* Ambiguity 13 remains UNMEASURED; it still wants a specimen.
*
* What the fixture is genuinely good for, and why it stays:
*
*   * The R-parallel-C arm — two drawn bodies between the same node pair,
*     which no earlier fixture presents. It is the sharpest specimen in
*     the suite for the X-layering's clique-expansion defect: a k-element
*     net becomes a k-clique, longest-path finds a Hamiltonian path
*     through it, and members that share a net get spread across k-1
*     layers instead of sharing one.
*   * Only the third fixture whose stimulus is DRAWN rather than
*     `;@ ignore`d (after `lc_ladder_lpf` and `sallen_key_driven`), so
*     the signal-flow root tier that CLAUDE.md's root-policy containment
*     argument rests on gains a third specimen.
*
* Electrically: R1/R2 set the 10:1 DC ratio; C1/C2 set the same ratio at
* HF, and the pole/zero cancel when R1*C1 == R2*C2 (810 ns here). The
* R-parallel-C arm is itself new to the suite — two drawn bodies between
* the same node pair, which no earlier fixture presents.
*@symbol Device:R_US           for=R*
*@symbol Device:C              for=C*
*@symbol Simulation_SPICE:VDC  for=VIN
*@port out=output

VIN in 0 DC 0 AC 1

R1 in  out 900k
C1 in  out 900f
R2 out 0   100k
C2 out 0   8.1p

.ac dec 20 10 100Meg
.end
