* Fifth-order LC ladder low-pass (50-ohm doubly-terminated, C-first).
* Two firsts for the benchmark, both deliberate:
*
*   1. The stimulus is DRAWN, not `;@ ignore`d. Every other fixture hides
*      its source, so `layers.rs::assign_x_layers` finds `sources` empty
*      and takes `no_source_fallback` 100% of the time — the principled
*      rooted-DAG layering path has never executed on a real fixture.
*      Here VIN is a Simulation_SPICE:VDC symbol on the sheet, so the
*      signal graph has a genuine root.
*   2. The suite's first inductors.
*
* Structurally it is a long chain (VIN -> RS -> L1 -> L2 -> L3 -> RL, with
* shunt capacitors hanging off every node), which is the shape the placer
* has no fold/aspect model for: Y extent stays put while X grows.
*@symbol Device:R_US           for=R*
*@symbol Device:C              for=C*
*@symbol Device:L              for=L*
*@symbol Simulation_SPICE:VDC  for=VIN
*@port out=output

VIN src 0   DC 0 AC 1

RS  src in  50

C1  in  0   3n3
L1  in  n2  10u
C2  n2  0   6n8
L2  n2  n3  10u
C3  n3  0   6n8
L3  n3  out 10u
C4  out 0   3n3
RL  out 0   50

.ac dec 20 10k 10Meg
.end
