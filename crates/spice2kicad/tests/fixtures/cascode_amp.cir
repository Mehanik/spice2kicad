* Cascode amplifier: a common-emitter Q1 underneath a common-base Q2.
* The defining feature is VERTICAL: Q2's emitter sits on Q1's collector,
* and the three-resistor bias chain RB1/RB2/RB3 is a vertical ladder from
* the rail to ground. The placer's model is layered left-to-right with no
* notion of a stack, so a circuit whose structure is a column is the
* natural stress case.
*@symbol Device:R_US      for=R*
*@symbol Device:C         for=C*
*@symbol Device:Q_NPN_BCE for=Q*
*@port in=input
*@port out=output

VCC vcc 0   DC 12         ;@ power=+12V
VIN in  0   AC 1          ;@ ignore

* --- the bias chain: vcc -> b2 -> b1 -> 0 ---
RB1 vcc b2  47k
RB2 b2  b1  22k
RB3 b1  0   10k
CB2 b2  0   10u

* --- the stack ---
RC  vcc c2  4k7
Q2  c2 b2 c1  QGENERIC
Q1  c1 b1 e1  QGENERIC
RE  e1  0   470
CE  e1  0   100u

CIN  in  b1 1u
COUT c2 out 1u
RL   out 0  100k          ;@ ignore

.model QGENERIC NPN (BF=200 IS=1e-15)
.ac dec 20 10 10Meg
.end
